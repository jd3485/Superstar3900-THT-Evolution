* V0.5 - VCO Colpitts 36.31..39MHz - open-loop candidate
* THIS IS NOT A VALIDATED MANUFACTURER MODEL OR A PRODUCTION DESIGN
* All board components THT. Q models generic approximate; varactor fit 3/30V only.
.title Superstar 3900 THT Evolution - RX only Colpitts VCO candidate
.param VCTRL=5.0
VCC V9 0 DC 9
VVTUNE VTUNE_RAIL 0 DC {VCTRL}
C500 V9 0 100n
C500B V9 0 10u
R501 V9 BASE1 33k
R502 BASE1 0 10k
C501 BASE1 0 1n
Q501 TANK BASE1 EMIT1 QGEN3904
R503 EMIT1 0 330
L501 V9 TANK 150n
C502 TANK EMIT1 68p
C503 EMIT1 0 220p
* Stray+trimmer+transistor Cjc: parasitics here are NOT characterized
C508 TANK 0 5p
C504 TANK VAR_A 1n
R505 VAR_A 0 100k
D501A VAR_A VTUNE_RAIL DBB204GFIT
D501B VAR_A VTUNE_RAIL DBB204GFIT
C505 VTUNE_RAIL 0 100n
C506 TANK BASE2 2.2p
R506 V9 BASE2 47k
R507 BASE2 0 22k
Q502 V9 BASE2 EMIT2 QGEN3904
R508 EMIT2 0 470
C507 EMIT2 LO1_ANALOG_OUT 100p
R509 LO1_ANALOG_OUT 0 1Meg
* GP model, approximate 2N3904; NOT an official MCC device model
.model QGEN3904 NPN (IS=6e-15 BF=180 VAF=100 IKF=0.05 CJE=8p CJC=3p TF=350p)
* Fit BB204G 36.5pF @3V and 14pF @30V using VJ=0.8V.
* This does NOT model lot tolerances, package inductance, tempco or RF Q.
.model DBB204GFIT D (IS=1e-12 RS=0.4 CJO=74.504229p VJ=0.8 M=0.4579444)
.ic v(TANK)=9.05 v(BASE1)=2.1 v(EMIT1)=1.4
.options reltol=0.001 abstol=1e-12
.tran 0.5n 25u 0 0.5n uic
.measure tran max_tank MAX v(TANK) FROM=15u TO=25u
.measure tran min_tank MIN v(TANK) FROM=15u TO=25u
.measure tran max_out MAX v(LO1_ANALOG_OUT) FROM=15u TO=25u
.measure tran min_out MIN v(LO1_ANALOG_OUT) FROM=15u TO=25u
.end
