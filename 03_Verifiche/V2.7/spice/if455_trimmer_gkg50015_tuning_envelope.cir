* Superstar3900 IF455 GKG50015 10-50pF THT TRIM CANDIDATE vs Delevan 1mH corners
* SIMULATION ONLY, 82pF fixed + adjustable 10 or 50pF: NO OEM RF MODEL / NO FAB.
* Actual Ctrim variable geometry, RF Q/ESR and coil parasitics not measured.
* Delevan DCR16.5ohm used as fictional RF series loss; not guaranteed Q at 455k.
.title 455kHz IF tank trimming envelope only
V_LMIN_MIN src_LMIN_MIN 0 DC 0 AC 1
RGEN_LMIN_MIN src_LMIN_MIN gen_LMIN_MIN 50
CIN_LMIN_MIN gen_LMIN_MIN tank_LMIN_MIN 10p
L_LMIN_MIN tank_LMIN_MIN loss_LMIN_MIN 0.95m
RLOSS_LMIN_MIN loss_LMIN_MIN 0 16.5
C1602_LMIN_MIN tank_LMIN_MIN 0 82p
CTRIM_LMIN_MIN tank_LMIN_MIN 0 10p
R1601_LMIN_MIN tank_LMIN_MIN 0 47k
COUT_LMIN_MIN tank_LMIN_MIN out_LMIN_MIN 10p
RLOAD_LMIN_MIN out_LMIN_MIN 0 100k
V_LMIN_MAX src_LMIN_MAX 0 DC 0 AC 1
RGEN_LMIN_MAX src_LMIN_MAX gen_LMIN_MAX 50
CIN_LMIN_MAX gen_LMIN_MAX tank_LMIN_MAX 10p
L_LMIN_MAX tank_LMIN_MAX loss_LMIN_MAX 0.95m
RLOSS_LMIN_MAX loss_LMIN_MAX 0 16.5
C1602_LMIN_MAX tank_LMIN_MAX 0 82p
CTRIM_LMIN_MAX tank_LMIN_MAX 0 50p
R1601_LMIN_MAX tank_LMIN_MAX 0 47k
COUT_LMIN_MAX tank_LMIN_MAX out_LMIN_MAX 10p
RLOAD_LMIN_MAX out_LMIN_MAX 0 100k
V_LNOM_MIN src_LNOM_MIN 0 DC 0 AC 1
RGEN_LNOM_MIN src_LNOM_MIN gen_LNOM_MIN 50
CIN_LNOM_MIN gen_LNOM_MIN tank_LNOM_MIN 10p
L_LNOM_MIN tank_LNOM_MIN loss_LNOM_MIN 1m
RLOSS_LNOM_MIN loss_LNOM_MIN 0 16.5
C1602_LNOM_MIN tank_LNOM_MIN 0 82p
CTRIM_LNOM_MIN tank_LNOM_MIN 0 10p
R1601_LNOM_MIN tank_LNOM_MIN 0 47k
COUT_LNOM_MIN tank_LNOM_MIN out_LNOM_MIN 10p
RLOAD_LNOM_MIN out_LNOM_MIN 0 100k
V_LNOM_MAX src_LNOM_MAX 0 DC 0 AC 1
RGEN_LNOM_MAX src_LNOM_MAX gen_LNOM_MAX 50
CIN_LNOM_MAX gen_LNOM_MAX tank_LNOM_MAX 10p
L_LNOM_MAX tank_LNOM_MAX loss_LNOM_MAX 1m
RLOSS_LNOM_MAX loss_LNOM_MAX 0 16.5
C1602_LNOM_MAX tank_LNOM_MAX 0 82p
CTRIM_LNOM_MAX tank_LNOM_MAX 0 50p
R1601_LNOM_MAX tank_LNOM_MAX 0 47k
COUT_LNOM_MAX tank_LNOM_MAX out_LNOM_MAX 10p
RLOAD_LNOM_MAX out_LNOM_MAX 0 100k
V_LMAX_MIN src_LMAX_MIN 0 DC 0 AC 1
RGEN_LMAX_MIN src_LMAX_MIN gen_LMAX_MIN 50
CIN_LMAX_MIN gen_LMAX_MIN tank_LMAX_MIN 10p
L_LMAX_MIN tank_LMAX_MIN loss_LMAX_MIN 1.05m
RLOSS_LMAX_MIN loss_LMAX_MIN 0 16.5
C1602_LMAX_MIN tank_LMAX_MIN 0 82p
CTRIM_LMAX_MIN tank_LMAX_MIN 0 10p
R1601_LMAX_MIN tank_LMAX_MIN 0 47k
COUT_LMAX_MIN tank_LMAX_MIN out_LMAX_MIN 10p
RLOAD_LMAX_MIN out_LMAX_MIN 0 100k
V_LMAX_MAX src_LMAX_MAX 0 DC 0 AC 1
RGEN_LMAX_MAX src_LMAX_MAX gen_LMAX_MAX 50
CIN_LMAX_MAX gen_LMAX_MAX tank_LMAX_MAX 10p
L_LMAX_MAX tank_LMAX_MAX loss_LMAX_MAX 1.05m
RLOSS_LMAX_MAX loss_LMAX_MAX 0 16.5
C1602_LMAX_MAX tank_LMAX_MAX 0 82p
CTRIM_LMAX_MAX tank_LMAX_MAX 0 50p
R1601_LMAX_MAX tank_LMAX_MAX 0 47k
COUT_LMAX_MAX tank_LMAX_MAX out_LMAX_MAX 10p
RLOAD_LMAX_MAX out_LMAX_MAX 0 100k
V_LPAR_MIN src_LPAR_MIN 0 DC 0 AC 1
RGEN_LPAR_MIN src_LPAR_MIN gen_LPAR_MIN 50
CIN_LPAR_MIN gen_LPAR_MIN tank_LPAR_MIN 10p
L_LPAR_MIN tank_LPAR_MIN loss_LPAR_MIN 1m
RLOSS_LPAR_MIN loss_LPAR_MIN 0 16.5
C1602_LPAR_MIN tank_LPAR_MIN 0 82p
CTRIM_LPAR_MIN tank_LPAR_MIN 0 10p
R1601_LPAR_MIN tank_LPAR_MIN 0 47k
COUT_LPAR_MIN tank_LPAR_MIN out_LPAR_MIN 10p
RLOAD_LPAR_MIN out_LPAR_MIN 0 100k
CPAR_LPAR_MIN tank_LPAR_MIN 0 3.23p
V_LPAR_MAX src_LPAR_MAX 0 DC 0 AC 1
RGEN_LPAR_MAX src_LPAR_MAX gen_LPAR_MAX 50
CIN_LPAR_MAX gen_LPAR_MAX tank_LPAR_MAX 10p
L_LPAR_MAX tank_LPAR_MAX loss_LPAR_MAX 1m
RLOSS_LPAR_MAX loss_LPAR_MAX 0 16.5
C1602_LPAR_MAX tank_LPAR_MAX 0 82p
CTRIM_LPAR_MAX tank_LPAR_MAX 0 50p
R1601_LPAR_MAX tank_LPAR_MAX 0 47k
COUT_LPAR_MAX tank_LPAR_MAX out_LPAR_MAX 10p
RLOAD_LPAR_MAX out_LPAR_MAX 0 100k
CPAR_LPAR_MAX tank_LPAR_MAX 0 3.23p
.control
set wr_singlescale
ac lin 1201 390k 550k
wrdata if455_trimmer_envelope_ac.dat vm(out_LMIN_MIN) vm(out_LMIN_MAX) vm(out_LNOM_MIN) vm(out_LNOM_MAX) vm(out_LMAX_MIN) vm(out_LMAX_MAX) vm(out_LPAR_MIN) vm(out_LPAR_MAX)
quit
.endc
.end
