* THT V2.7 IF455 tank directly feeding AM455 diode: NONLINEAR transient hypothesis.
* AM-only. Generic DGENERIC, NOT an OEM 1N4148 macromodel. NO FAB/NO TX.
* Tank: 1mH, 82p + 30p trimmer, source 50ohm, coupling 10p at both ends.
* 16.5ohm AC coil-loss is a simplifying assumption, NOT RF ESR qualification.
* Compare coupled tank+detector versus direct 50ohm+detector at equal excitation.
.title IF455 to AM455 generic diode transient study NO FAB
.param fc=455k fa=1k depth=0.5 amp=2
BIF src_if 0 V={(amp*(1+depth*sin(2*pi*fa*time))*sin(2*pi*fc*time))}
RGEN src_if gen 50
C1601 gen tank 10p
L1601 tank ltail 1m
RCOIL ltail 0 16.5
C1602 tank 0 82p
C1603 tank 0 30p
R1601 tank 0 47k
C1604 tank out 10p
R1602 out 0 100k
D1501 out envelope DGENERIC
R1501 envelope 0 47k
C1501 envelope 0 1n
C1502 envelope af 100n
R1502 af 0 100k
* Direct reference detector without the tank -- NOT a recommendation.
BREF src_ref 0 V={(amp*(1+depth*sin(2*pi*fa*time))*sin(2*pi*fc*time))}
RREF src_ref direct 50
DREF direct env_ref DGENERIC
RREF_LOAD env_ref 0 47k
CREF_ENV env_ref 0 1n
CREF_COUPLE env_ref af_ref 100n
RREF_AUDIO af_ref 0 100k
.model DGENERIC D(Is=2.5n N=1.9 Rs=0.6 Cjo=4p Vj=0.75 Tt=4n)
.tran 0.2u 12m 0 0.2u
.meas tran coupled_max MAX v(af) FROM=8m TO=11m
.meas tran coupled_min MIN v(af) FROM=8m TO=11m
.meas tran direct_max MAX v(af_ref) FROM=8m TO=11m
.meas tran direct_min MIN v(af_ref) FROM=8m TO=11m
.meas tran rf_out_peak MAX v(out) FROM=8m TO=11m
.end
