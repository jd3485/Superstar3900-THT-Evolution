* Independent 2-stage series sink LAB SIMULATION ONLY; NO HARDWARE QUALIFICATION
* Two independent ideal behavioural servos, generic BJTs, not vendor models.
* Main regulates ~40uA via first emitter sense; guard ceiling ~45uA via second.
* Connected 5V laboratory source only, unknown actual movement FSD and coil.
VDD VDD 0 5
VSETMAIN CMD_MAIN 0 0.4
VSETGUARD CMD_GUARD 0 0.45
RCOIL VDD METER_LOW 2000
QMAIN METER_LOW BASE_MAIN SENSE_MAIN QGEN
RS_MAIN SENSE_MAIN GUARD_COLL 10000
QGUARD GUARD_COLL BASE_GUARD SENSE_GUARD QGEN
RS_GUARD SENSE_GUARD 0 10000
BMAIN DRIVE_MAIN 0 V = min(max(5000*(V(CMD_MAIN)-(V(SENSE_MAIN)-V(GUARD_COLL))),0),max(V(VDD),0))
BGUARD DRIVE_GUARD 0 V = min(max(5000*(V(CMD_GUARD)-V(SENSE_GUARD)),0),max(V(VDD),0))
RBMAIN DRIVE_MAIN BASE_MAIN 10000
RBGUARD DRIVE_GUARD BASE_GUARD 10000
RPMAIN BASE_MAIN 0 100000
RPGUARD BASE_GUARD 0 100000
.model QGEN NPN(IS=6e-15 BF=100 VAF=80 CJE=12p CJC=4p)
.op
.end
